* cr11x_csp.cir -- CR-11X charge-sensitive preamplifier, SPICE netlist
* ============================================================================
* track A2 csp-sim. Netlist EXTRACTED / re-expressed from Cremat's official
* CR-110-R2 LTspice model (CR-110-R2.asc) -- the §5 path-1 "portable netlist"
* route. Two-stage architecture (charge integrator -> voltage amp -> 50 ohm
* output) and the feedback/input cap topology are Cremat's; component VALUES are
* set per the chosen part's datasheet via the .param block.
*
* The op-amps use the SAME open-loop params as Cremat's UniversalOpamp2 in the
* .asc (U1 Avol=3000/GBW=680MEG, U2 Avol=1MEG/GBW=500MEG) so the bandwidth/
* rise-time dynamics match the official model. Output is a unity buffer + 50 ohm
* (datasheet Zout=50). Overall charge gain = G2 / Cf.
*
* Run in LTspice batch:  LTspice.exe -b -Run cr11x_csp.cir   (-> cr11x_csp.raw)
* Switch part by editing the single .param line below.
* ============================================================================

* ---- PART SELECT (default = CR-112 target) -------------------------------
* CR-112 ds: Cf=75p, Rf=680k, gain 13 mV/pC, tau=51us, tr~3ns.  G2=1 -> 1/Cf=13.3mV/pC.
.param Cf=1.4p  Rf=100Meg Cin=15p   G2=2.0
* --- alternates (uncomment one to validate) ---
* CR-110 (Cremat model & ds 1.4 V/pC): .param Cf=1.4p Rf=100Meg Cin=15p G2=2.0
* CR-111 (ds 67 mV/pC):                .param Cf=15p  Rf=10Meg  Cin=10p G2=1.0
* CR-113 (ds 1.3 mV/pC):               .param Cf=750p Rf=68k    Cin=30p G2=1.0

* ============================ TEST BENCH ====================================
* Ideal +/-6 V rails (datasheet operating point). Support-circuit decoupling is
* the A1-design concern and does not move the transient FoM here.
Vpos  pVs  0  6
Vneg  nVs  0  -6

* Ideal 0.5 pC charge impulse INTO the CSP input.
* Near-ideal impulse: 100 ps FWHM triangle, peak 10 mA -> area = 0.5*10mA*100ps = 0.5pC.
*   (much shorter than the amplifier response, so the measured CSP_OUT rise time is
*    the amplifier's intrinsic value, not the stimulus width.)
* Current source from node 0 to 'input' pushes +0.5 pC of charge into the input.
Iinj  0  input  PWL(0 0  999.95n 0  1000.00n 10m  1000.05n 0  300u 0)

* ====================== CR-11X internal model ================================
* Input / detector capacitance to ground (Cremat model C3).
C3  input  0  {Cin}

* ---- Stage 1: charge integrator (inverting), feedback Cf || Rf ----
* Q into 'input' -> V(n_o1) = -Q/Cf, decaying with tau = Rf*Cf.
Cf  n_o1  input  {Cf}
Rf  n_o1  input  {Rf}
XU1 0 input n_o1  pVs nVs  opamp1

* ---- Stage 2: voltage amp, gain = G2 (ideal, rail-limited VCVS) ----
* Driven by the integrator output n_o1. A single behavioral gain block keeps
* the calibration unambiguous (G2=1 -> unity for CR-112) and avoids a 0-ohm R.
BU2 n_o2a 0 V=limit( {G2}*V(n_o1), V(nVs)+0.2, V(pVs)-0.2 )
Ro2 n_o2a 0 1G

* ---- Output-bandwidth pole (sets the CR-112 ~3 ns rise time per datasheet) ----
* Cremat's full transistor model has finite output bandwidth that a single-pole
* op-amp macromodel omits, so add an explicit pole. Datasheet rise time tr~3 ns
* (zero added input cap); a single-pole 10-90% rise tr = ln(9)/(2*pi*fbw).
* tr=3ns -> fbw=116.6 MHz -> Rbw*Cbw = 1.366 ns. Use Rbw=50, Cbw=27.3p.
.param Rbw=50 Cbw=27.3p
Rbw n_o2a n_o2  {Rbw}
Cbw n_o2  0     {Cbw}

* ---- Output: unity buffer + 50 ohm series (datasheet Zout = 50) ----
* The op-amp gives a low source impedance; R3 sets the 50-ohm output impedance.
XU3 n_o2 nbuf nbuf  pVs nVs  opamp2
R3  nbuf  CSP_OUT  50
Rload CSP_OUT 0 1Meg

* ============================ OP-AMP SUBCKTS ================================
* Single-pole VCVS op-amp reproducing Cremat UniversalOpamp2 params:
*   A(s) = Avol / (1 + s/wp), wp = 2*pi*GBW/Avol ; rail-limited output.
.subckt opamp1 inp inn out vcc vee
.param Avol1=3000 GBW1=680e6
.param wp1 = 6.283185*GBW1/Avol1
Gm  0 n1  inp inn  1
Rp  n1 0  {Avol1}
Cp  n1 0  {1/(Avol1*wp1)}
Bout out 0 V=limit( V(n1), V(vee)+0.2, V(vcc)-0.2 )
Rout out 0 1G
.ends opamp1

.subckt opamp2 inp inn out vcc vee
.param Avol2=1e6 GBW2=500e6
.param wp2 = 6.283185*GBW2/Avol2
Gm  0 n1  inp inn  1
Rp  n1 0  {Avol2}
Cp  n1 0  {1/(Avol2*wp2)}
Bout out 0 V=limit( V(n1), V(vee)+0.2, V(vcc)-0.2 )
Rout out 0 1G
.ends opamp2

* ============================== ANALYSIS ===================================
.tran 0 300u 0 50p uic
.save V(input) V(CSP_OUT) V(n_o1) V(n_o2) I(Iinj)
.end
